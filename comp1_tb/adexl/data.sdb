ADE simulation setup
Run mode: Single Run, Sweeps and Corners
Tests:
  cis:comp1_tb:1: cis/comp1_tb/schematic, simulator spectre
