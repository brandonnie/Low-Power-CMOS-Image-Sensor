ADE simulation setup
Run mode: Single Run, Sweeps and Corners
Tests:
  cis:diff_idac_tb:1: cis/diff_idac_tb/schematic, simulator spectre
