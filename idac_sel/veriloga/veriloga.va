// VerilogA for cis, idac_sel, veriloga

`include "constants.vams"
`include "disciplines.vams"

`define BITS 8

module idac_sel (out, in);
    parameter real VIN_MAX = 1.0;
    parameter real V_LO = 0.0;
    parameter real V_HI = 1.2;
    //parameter real V_HI = 2.5;

    localparam real QUANT = VIN_MAX / (2 ** `BITS);

    output [0:`BITS-1] out;
    input in;
    electrical [0:`BITS-1] out;
    electrical in;

    integer level;

    analog begin
        level = $floor(V(in) / QUANT);

        generate i (`BITS - 1, 0) begin
            if (level & (1 << i)) begin
                V(out[i]) <+ V_HI;
            end else begin
                V(out[i]) <+ V_LO;
            end
        end
    end

endmodule
